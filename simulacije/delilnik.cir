Delilnik napetosti (Ngspice različica)

* 1. Definiramo elemente s fiksnimi začetnimi vrednostmi
v0 2 0 dc 3V
r2 2 1 1k
r1 1 0 100k

.control
  destroy all

  * V Ngspice poženemo DC sweep nad parametrom 'r' upora r2
  dc r2 1 5meg 500

  set color0 = white
  set color1=black

  set hcopydevtype = svg
  * Ukaz hardcopy shrani graf v datoteko namesto prikaza na zaslonu
  hardcopy out/delilnik_graf.svg v(1) xlabel 'Upornost kože' ylabel 'Izhodna napetost Vdel'

  * SAMODEJNI IZHOD
  quit
.endc

.end
